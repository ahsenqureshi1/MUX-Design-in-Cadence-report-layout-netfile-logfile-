// Design: Project2/tb_Project2
simulator lang=spectre
global 0
parameters temperature=27 Wn_w=0.57143u Wp_w=0.42857u Wn_a=1.3u Wn_b=3.1u Wn_c=6.1u Wp_a=0.95u Wp_b=2.85u Wp_c=4.05u vin=1 vin_A=0 vin_B=1
include "/CMC/kits/GPDK45/gpdk045_v_6_0/gpdk045/../models/spectre/gpdk045.scs" section=mc

// Project2/inv_1/schematic
subckt inv_1 VDD VIN VOUT VSS
    NM0 (VOUT VIN VSS VSS) g45n1svt w=(48u) l=45n nf=5 m=(1)
    PM0 (VOUT VIN VDD VDD) g45p1svt w=(72u) l=45n nf=8 m=(1)
ends inv_1

// Project2/nand_w/schematic
subckt nand_w A B VDD VSS VOUT
    NM4 (net9 B VSS VSS) g45n1svt w=(570n) l=45n nf=1 m=(1)
    NM2 (VOUT A net9 VSS) g45n1svt w=(570n) l=45n nf=1 m=(1)
    PM2 (VOUT B VDD VDD) g45p1svt w=(430n) l=45n nf=1 m=(1)
    PM1 (VOUT A VDD VDD) g45p1svt w=(430n) l=45n nf=1 m=(1)
ends nand_w

// Project2/nand_a/schematic
subckt nand_a A B VDD VSS VOUT
    NM4 (net9 B VSS VSS) g45n1svt w=(1.3u) l=45n nf=1 m=(1)
    NM2 (VOUT A net9 VSS) g45n1svt w=(1.3u) l=45n nf=1 m=(1)
    PM2 (VOUT B VDD VDD) g45p1svt w=(950n) l=45n nf=1 m=(1)
    PM1 (VOUT A VDD VDD) g45p1svt w=(950n) l=45n nf=1 m=(1)
ends nand_a

// Project2/inv_b/schematic
subckt inv_b VDD VIN VOUT VSS
    NM0 (VOUT VIN VSS VSS) g45n1svt w=(3.1u) l=45n nf=1 m=(1)
    PM0 (VOUT VIN VDD VDD) g45p1svt w=(2.85u) l=45n nf=1 m=(1)
ends inv_b

// Project2/inv_c/schematic
subckt inv_c VDD VIN VOUT VSS
    NM0 (VOUT VIN VSS VSS) g45n1svt w=(12.2u) l=45n nf=2 m=(1)
    PM0 (VOUT VIN VDD VDD) g45p1svt w=(8.1u) l=45n nf=2 m=(1)
ends inv_c

// Project2/MUX/schematic
subckt MUX A B Sel Sel\* VDD VSS VOUT
    I12 (B Sel\* VDD VSS net3) nand_w
    I8 (A Sel VDD VSS net8) nand_w
    I9 (net8 net3 VDD VSS net10) nand_a
    I10 (VDD net10 net15 VSS) inv_b
    I11 (VDD net15 VOUT VSS) inv_c
ends MUX

// Project2/tb_Project2/schematic
I0 (VDD Y net2 VSS) inv_1
V3 (Sel_bar 0) vsource type=pulse val0=vin val1=0 period=2n rise=5p fall=5p width=1n
V2 (Sel 0) vsource type=pulse val0=0 val1=vin period=2n rise=5p fall=5p width=1n
I14 (A B Sel Sel_bar VDD VSS Y) MUX
V6 (A 0) vsource dc=vin_A type=dc
V5 (VSS 0) vsource dc=0 type=dc
V4 (VDD 0) vsource dc=1 type=dc
V7 (B 0) vsource dc=vin_B type=dc
simulatorOptions options temp=27
tran tran stop=9n errpreset=conservative
save A B Sel Sel_bar Y
